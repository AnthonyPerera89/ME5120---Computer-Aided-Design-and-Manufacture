* SIM09e_load_transient  Load transient: 10 mA <-> 0.8 A at 18 V and 3 V
* FINAL CIRCUIT (frozen values) - this is the report simulation.
* Load step at 1 ms (on) and 2 ms (off), CC = 500 pF.
* Report figure 5: V(out) zoom on the step with I(ILOAD) underneath, both VOUT settings.
.include ../lib/LM723_macro.lib
.include ../lib/transistors_ds.lib
.param VADV=24 Rcl=0 Rp=10k
* ---- final circuit (frozen values) ----
VAD   vad 0 {VADV}
RSRC  vad vj 1m
RF1   vj vin 0.15
D3    0 d3k DSS34
RD3   d3k vin 1m
CIN   vin 0 470u
CIN2  vin 0 100n
RLED  vin led 10k
DLED  led 0 DLEDRED
IMTR  vin 0 20m
XU1   vin 0 vin b vref ni inv comp out out LM723
Q4    vin b bt BD139DS
RBE   bt e 470
Q1    vin bt e TIP3055DS
RSC   e out 0.56
Q2    comp bl out BC547BDS
RCL   bl n1 {Rcl+1m}
RBL   n1 e 47
D1    vin d1 D1N4148
D2    d1 qb D1N4148
RBQ   qb 0 22k
RE    vin qe 680
Q3    bl qb qe BC557BDS
RA    vref ni 4.7k
RB    ni 0 3.3k
CNI   ni 0 4.7u
C1    comp inv 500p
RPOT  out inv {Rp+1m}
RFIX  inv trim 1.30k
RTRIM trim 0 660
COUT  out co 100u
RESR  co 0 0.1
CHF   out 0 100n
RSH   outm 0 10m
ILOAD out outm PULSE(10m 800m 1m 1u 1u 1m 3m)
.step param Rp list 0 10k
.tran 0 3m 0.5m 1u
.meas TRAN vdip_V MIN V(out) FROM 1m TO 1.5m
.meas TRAN vpeak_V MAX V(out) FROM 2m TO 2.5m
.end
